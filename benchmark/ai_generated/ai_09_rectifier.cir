* Half-wave rectifier with 1N4148 diode and smoothing capacitor
* 50 Hz mains-frequency input, simplified low-voltage version

Vin in 0 SIN(0 12 50)
D1 in out 1N4148
Cout out 0 100u
Rload out 0 1k

.model 1N4148 D(IS=4.352n N=1.906 BV=110 IBV=0.0001 RS=0.6458 CJO=7.048p VJ=0.869 M=0.03 FC=0.5 TT=3.48n)

.tran 0.1m 60m

.control
run
plot v(in) v(out)
.endc

.end

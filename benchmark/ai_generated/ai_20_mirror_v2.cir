* NPN current mirror, 1mA reference current
* Q1 diode-connected sets reference; Q2 mirrors into the load

Vcc 1 0 12
Rref 1 2 11k
Q1 2 2 0 2N3904
Q2 3 2 0 2N3904
Rout 1 3 4.7k

.model 2N3904 NPN(IS=6.734f BF=416.4 VAF=74.03 IKF=66.78m NE=1.259 ISE=6.734f)

.op

.control
run
print i(Vcc) v(2) v(3)
.endc

.end

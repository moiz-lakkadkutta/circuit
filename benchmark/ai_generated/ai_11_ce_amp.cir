* Common-Emitter NPN Amplifier, 12V rail
* Shows DC bias point (.op)

Vcc vcc 0 DC 12
Vin in 0 DC 0 AC 1 SIN(0 0.01 1k)

R1 vcc base 47k
R2 base 0 10k
Rc vcc coll 2.2k
Re emit 0 1k
Cin in base 10u
Cout coll out 10u
Ce emit 0 100u
Rload out 0 10k

Q1 coll base emit QNPN

.model QNPN NPN(BF=100 IS=1e-14 VAF=100)

.op

.control
run
print v(base) v(coll) v(emit) i(Vcc)
.endc

.end

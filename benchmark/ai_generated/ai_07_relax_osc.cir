* 555-style relaxation oscillator using an ideal comparator
* RC timing network sets frequency; comparator provides hysteresis (Schmitt trigger)

Vcc vcc 0 DC 12

* Timing RC
R1 vcc tim 10k
C1 tim 0 100n

* Comparator with hysteresis feedback (ideal, behavioral)
Ecomp out 0 TABLE {v(tim) - v(fb)} = (-1m,0) (1m,12)

* Feedback divider sets thresholds at 1/3 and 2/3 Vcc
Rfb1 out fb 10k
Rfb2 fb 0 10k

* Discharge path controlled by comparator output (simplified with switch model)
Sdis tim dis out 0 SWMOD
Rdis dis 0 100

.model SWMOD SW(VT=6 VH=0.1 RON=10 ROFF=1MEG)

.tran 10u 5m

.control
run
plot v(tim) v(out)
.endc

.end

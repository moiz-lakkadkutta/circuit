* Ideal-switch buck converter, 12V input -> 5V output target
* fsw = 200kHz, D approx 5/12 = 0.417

Vin 1 0 12

Vpwm gate 0 PULSE(0 5 0 5n 5n 2.08u 5u)
S1 1 sw gate 0 SWQ
.model SWQ SW(VT=2.5 VH=0.2 RON=0.05 ROFF=100k)

Dfree 0 sw DFAST
.model DFAST D(IS=1e-14 RS=0.02 TT=10n)

L1 sw out 47u
Resr out out2 0.05
Cout out2 0 220u
Rload out2 0 5

.tran 50n 3m 0 50n

.control
run
plot v(out2)
.endc

.end
